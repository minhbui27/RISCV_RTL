ADE simulation setup
Test ECE224_GITHUB_tb_AND5X1_1: ECE224_GITHUB/tb_AND5X1/schematic, simulator hspiceD
  Models: /fs/student/chanwhopark/ncsu45_template/hspice_nom.include
  Variables: vddi = 1
  Analysis tran: start=0 stop=180n step=10p
  Signals: /out, /In<0:4>
Run mode: Single Run, Sweeps and Corners
