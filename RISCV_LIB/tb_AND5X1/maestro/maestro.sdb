ADE simulation setup
Run mode: Single Run, Sweeps and Corners
Tests:
  ECE224_GITHUB_tb_AND5X1_1: ECE224_GITHUB/tb_AND5X1/schematic, simulator hspiceD
    Variables: vddi = 1
    Outputs: /out; "/In"; "/In<0:4>"; /In<0:4>
