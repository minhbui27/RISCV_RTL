ADE simulation setup
Run mode: Single Run, Sweeps and Corners
Tests:
  ECE224_GITHUB_tb_RegFile_READ_1: ECE224_GITHUB/tb_RegFile_READ/schematic, simulator hspiceD
    Variables: vddi = 1
    Outputs: /wr_addr<0:4>; /wr1_en; /pchb; /wr1_di<0:31>; /sa1_en; /rs1_out; "/I0/I4/BL<0:31>"; /rs1_addr<0:4>; /rs1_out<0:31>; /I0/WL1<0:31>; "/I0/I4/BL1B<0:31>"; "/I0/I4/BL1<0:31>"; /I0/I4/BL1B<0:31>; /I0/I4/BL1<0:31>; "/I0/rs1_<0:31>"; "/"; /; /I0/wr_WL<0:31>; /I0/rs1_<0:31>; /I0/rs1_WL<0:31>
