ADE simulation setup
Test ECE224_GITHUB_tb_RegFile_READ_1: ECE224_GITHUB/tb_RegFile_READ/schematic, simulator hspiceD
  Models: /fs/student/chanwhopark/ncsu45_template/hspice_nom.include
  Variables: vddi = 1
  Analysis tran: start=0 stop=100n step=10p
  Signals: /wr_addr<0:4>, /wr1_en, /wr1_di<0:31>, /rs1_addr<0:4>, /I0/WL1<0:31>, /I0/rs1_WL<0:31>, /I0/wr_WL<0:31>
Run mode: Single Run, Sweeps and Corners
