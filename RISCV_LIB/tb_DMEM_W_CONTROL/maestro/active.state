ADE simulation setup
Test RISCV_LIB_tb_DMEM_W_CONTROL_1: RISCV_LIB/tb_DMEM_W_CONTROL/schematic, simulator hspiceD
  Models: /fs/student/chanwhopark/ncsu45_template/hspice_nom.include
  Variables: vddi = 1
  Analysis tran: start=0 stop=240n step=10p
  Signals: /I0/clk, /ck, /I0/I33/MEM_WR_FF, /addr<0:4>, /I0/addr_en, /I0/WL<0:31>, /wr_data<0:31>, /mem_wr, /I0/pchb, /I0/sa_en, /I0/BL<0>, /I0/BLb<0>, /dmem_o<0:31>, /I0/I0/I0/I0/I0/Q, /I0/I0/I0/I0/I1/Q
Run mode: Single Run, Sweeps and Corners
