ADE simulation setup
Run mode: Single Run, Sweeps and Corners
Tests:
  RISCV_LIB_tb_DMEM_W_CONTROL_1: RISCV_LIB/tb_DMEM_W_CONTROL/schematic, simulator hspiceD
    Variables: vddi = 1
    Outputs: /addr<0:4>; /wr_data<0:31>; /mem_wr; /ck; /dmem_o<0:31>; /I0/addr_en; /I0/sa_en; /I0/pchb; /I0/BL<0:31>; /I0/BL<0>; /I0/BLb<0>; /x; /I0/half_ck; /I0/half_ckb; /I0/WL<0:31>; /I0/I0/I0/I0/I0/Q; /I0/I0/I0/I0/I1/Q; /I0/net2; /I0/clk; /I0/I33/Q1; /I0/I33/Q2; /I0/I33/MEM_WR_FF; /I0/I33/A; /I0/I33/B; /X; /I0/I33/D; /I0/I33/C; /I0/I33/Q0; /I0/I33/Q3; /I0/I33/B0; /I0/I33/B1
