ADE simulation setup
Test RISCV_LIB_tb_DMEM_32X32_1: RISCV_LIB/tb_DMEM_32X32/schematic, simulator hspiceD
  Models: /fs/student/chanwhopark/ncsu45_template/hspice_nom.include
  Variables: vddi = 1
  Analysis tran: start=0 stop=50n step=10p
  Signals: /addr<0:4>, /sa_en, /pchb, /mem_wr, /wr_data<0:31>, /dmem_o<0:31>, /I0/BL<0>, /I0/BLb<0>, /I0/I0/I0/I0/I0/Q, /I0/I0/I0/I0/I1/Q, /addr_en, /ck, /I0/WL<0:31>
Run mode: Single Run, Sweeps and Corners
