ADE simulation setup
Run mode: Single Run, Sweeps and Corners
Tests:
  00_ECE224A_SRAM_TUTORIAL_tb_tb_SRAM_WLDEC4_CP_1: 00_ECE224A_SRAM_TUTORIAL_tb/tb_SRAM_WLDEC4_CP/schematic, simulator hspiceD
    Variables: vddi = 1
    Outputs: /wl<0:3>
