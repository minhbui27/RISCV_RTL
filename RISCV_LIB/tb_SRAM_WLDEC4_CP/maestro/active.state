ADE simulation setup
Test 00_ECE224A_SRAM_TUTORIAL_tb_tb_SRAM_WLDEC4_CP_1: 00_ECE224A_SRAM_TUTORIAL_tb/tb_SRAM_WLDEC4_CP/schematic, simulator hspiceD
  Models: /fs/student/chanwhopark/ncsu45_template/hspice_nom.include
  Variables: vddi = 1
  Analysis tran: start=0 stop=100n step=10p
  Signals: /addr<0>, /addr<1>, /ck, /addr_en, /wl<0:3>
Run mode: Single Run, Sweeps and Corners
