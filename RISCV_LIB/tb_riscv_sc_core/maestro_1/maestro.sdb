ADE simulation setup
Run mode: Single Run, Sweeps and Corners
Tests:
  RISCV_LIB_tb_riscv_sc_core_1: RISCV_LIB/tb_riscv_sc_core/schematic, simulator hspiceD
    Variables: vddi = 1
    Outputs: /8th_clk; /vdd_imem; /vdd; /I6/I2/BL<0:31>; /immem_pchb; /I6/I2/I0/I0/I0/I0/Q; /I6/inst<0:31>; "/u"; /u; /rst; /bootload; /I6/pc<0:4>; /I6/imem_pchb; /bl_imem_wr; /I6/imem_addr_en; /wr_data<0:31>; /I6/sc_pc<0:31>; /I6/I2/BLb<0:31>; /I6/I2/WL<0:31>; /I6/clk; /I6/imem_sa_en; /I6/sc_imem_pchb; /I6/sc_imem_addr_en
