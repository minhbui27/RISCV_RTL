ADE simulation setup
Run mode: Single Run, Sweeps and Corners
Tests:
  RISCV_LIB_tb_riscv_sc_core_1: RISCV_LIB/tb_riscv_sc_core/schematic, simulator hspiceD
    Variables: vddi = 1
    Outputs: /8th_clk; /vdd_imem; /vdd; /I6/I2/BL<0:31>; /immem_pchb; /I6/I2/I0/I0/I0/I0/Q; /I6/inst<0:31>; "/u"; /u; /rst; /bootload; /I6/pc<0:4>; /I6/imem_pchb; /bl_imem_wr; /I6/imem_addr_en; /wr_data<0:31>; /I6/sc_pc<0:31>; /I6/I2/BLb<0:31>; /I6/I2/WL<0:31>; /I6/clk; /I6/imem_sa_en; /I6/sc_imem_pchb; /I6/sc_imem_addr_en; /I6/alu_b; /I6/alu_a; /I6/alu_out<0:31>; /I6/rs1; /I6/rs2; /I6/inst<15:19>; /I6/inst<20:24>; /I6/dmem_wr; /I6/reg_addr_en; /I6/reg_sa_en; /I6/reg_pchb; /I6/dmem_addr_en; /I6/dmem_pchb; /I6/alu_op<0:3>; /I6/reg_wr; /I6/wb_data<0:31>; /I6/pc_p4<0:31>; /I6/net3<0:31>; /I6/rs1<0:31>; /I6/rs2<0:31>; /I6/alu_b<0:31>; /I6/alu_a<0:31>; /I6/immo<0:31>; /I6/sel_wb<0:1>; /I6/I3/I4/BL1<0:31>; /I6/I3/I4/BL1B<0:31>; /I6/I3/I4/net4<0:31>; /I6/I3/I4/BL2<0:31>; /I6/I3/I4/BL2B<0:31>; /I6/I9/BL<0:31>; /I6/I9/BLb<0:31>; /I6/I11/S_type; /I6/I11/R_type; /I6/I11/J_type; /I6/I11/I_load_type; /I6/I11/I_arith_type; /I6/I11/B_type; /I6/net45; /I6/br_en
