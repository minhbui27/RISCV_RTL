ADE simulation setup
Run mode: Single Run, Sweeps and Corners
Tests:
  RISCV_LIB_tb_riscv_sc_core_1: RISCV_LIB/tb_riscv_sc_core/schematic, simulator hspiceD
    Variables: vddi = 1
    Outputs: /8th_clk; /vdd_imem; /vdd; /imem_wr; /imem_addr_en; /wr_data<0:31>; /pc<0:4>; /I6/I2/WL<0:31>; /I6/I2/BL<0:31>; /immem_pchb; /imem_pchb; /I6/I2/I0/I0/I0/I0/Q; /I6/inst<0:31>; /rst; /buf_en; /imem_wr_buf; /pc_buf<0:4>; /imem_addr_en_buf; /imem_pchb_buf
