ADE simulation setup
Test RISCV_LIB_tb_riscv_sc_core_1: RISCV_LIB/tb_riscv_sc_core/schematic, simulator hspiceD
  Models: /fs/student/chanwhopark/ncsu45_template/hspice_nom.include
  Variables: vddi = 1
  Analysis tran: start=0 stop=165n step=1n
  Signals: /8th_clk, /I6/clk, /rst, /vdd_imem, /vdd, /bootload, /I6/inst<0:31>, /I6/pc<0:4>, /I6/sc_pc<0:31>, /I6/imem_pchb, /I6/sc_imem_pchb, /I6/imem_addr_en, /I6/sc_imem_addr_en, /I6/imem_sa_en, /I6/I2/WL<0:31>, /bl_imem_wr, /wr_data<0:31>, /I6/I2/BL<0:31>, /I6/I2/BLb<0:31>, /I6/reg_pchb, /I6/reg_sa_en, /I6/reg_addr_en, /I6/reg_wr, /I6/wb_data<0:31>, /I6/rs1<0:31>, /I6/rs2<0:31>, /I6/inst<15:19>, /I6/inst<20:24>, /I6/alu_op<0:3>, /I6/alu_b<0:31>, /I6/alu_a<0:31>, /I6/alu_out<0:31>, /I6/dmem_wr, /I6/dmem_addr_en, /I6/dmem_pchb, /I6/pc_p4<0:31>, /I6/net3<0:31>, /I6/immo<0:31>, /I6/sel_wb<0:1>, /I6/I3/I4/BL1<0:31>, /I6/I3/I4/BL1B<0:31>, /I6/I3/I4/BL2B<0:31>, /I6/I3/I4/BL2<0:31>, /I6/I9/BL<0:31>, /I6/I9/BLb<0:31>, /I6/I11/B_type, /I6/I11/S_type, /I6/I11/R_type, /I6/I11/J_type, /I6/I11/I_load_type, /I6/I11/I_arith_type, /I6/br_en
Run mode: Single Run, Sweeps and Corners
