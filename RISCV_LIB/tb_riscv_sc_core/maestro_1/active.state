ADE simulation setup
Test RISCV_LIB_tb_riscv_sc_core_1: RISCV_LIB/tb_riscv_sc_core/schematic, simulator hspiceD
  Models: /fs/student/chanwhopark/ncsu45_template/hspice_nom.include
  Variables: vddi = 1
  Analysis tran: start=0 stop=40n step=1n
  Signals: /8th_clk, /rst, /vdd_imem, /vdd, /bootload, /I6/I2/BL<0:31>, /I6/I2/BLb<0:31>, /I6/inst<0:31>, /I6/pc<0:4>, /I6/imem_pchb, /bl_imem_wr, /I6/imem_addr_en, /wr_data<0:31>, /I6/sc_pc<0:31>, /I6/I2/WL<0:31>, /I6/clk, /I6/imem_sa_en, /I6/sc_imem_pchb, /I6/sc_imem_addr_en
Run mode: Single Run, Sweeps and Corners
