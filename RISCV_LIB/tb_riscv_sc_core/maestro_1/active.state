ADE simulation setup
Test RISCV_LIB_tb_riscv_sc_core_1: RISCV_LIB/tb_riscv_sc_core/schematic, simulator hspiceD
  Models: /fs/student/chanwhopark/ncsu45_template/hspice_nom.include
  Variables: vddi = 1
  Analysis tran: start=0 stop=40n step=1n
  Signals: /8th_clk, /vdd_imem, /vdd, /imem_wr, /imem_addr_en, /wr_data<0:31>, /pc<0:4>, /I6/I2/WL<0:31>, /I6/I2/BL<0:31>, /imem_pchb, /I6/I2/I0/I0/I0/I0/Q, /I6/inst<0:31>, /rst, /buf_en, /imem_wr_buf, /pc_buf<0:4>, /imem_addr_en_buf, /imem_pchb_buf
Run mode: Single Run, Sweeps and Corners
