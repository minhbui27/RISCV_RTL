ADE simulation setup
Run mode: Single Run, Sweeps and Corners
Tests:
  ECE224_GITHUB_tb_Decoder_5bto32_1: ECE224_GITHUB/tb_Decoder_5bto32/schematic, simulator hspiceD
    Variables: vddi = 1
    Outputs: /OUT<0:31>; /In<0:4>
