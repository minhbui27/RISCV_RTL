ADE simulation setup
Test ECE224_GITHUB_tb_Decoder_5bto32_1: ECE224_GITHUB/tb_Decoder_5bto32/schematic, simulator hspiceD
  Models: /fs/student/chanwhopark/ncsu45_template/hspice_nom.include
  Variables: vddi = 1
  Analysis tran: start=0 stop=160n step=10p
  Signals: /OUT<0:31>, /In<0:4>
Run mode: Single Run, Sweeps and Corners
