ADE simulation setup
Test RISCV_LIB_tb_8TSRAM_READ_1: RISCV_LIB/tb_8TSRAM_READ/schematic, simulator spectre
  Models: /fs/student/chanwhopark/ncsu45_template/hspice_nom.include
  Variables: vddi = 1
  Temperature: 27
  Analysis tran: start=0 stop=30n step=10p
  Signals: /out_sa1, /out_sa2, /pchb1, /pchb2, /bl1, /bl2, /net2, /net1, /sae1, /sae2
Run mode: Single Run, Sweeps and Corners
