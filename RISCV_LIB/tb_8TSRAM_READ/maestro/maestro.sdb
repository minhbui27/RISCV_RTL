ADE simulation setup
Run mode: Single Run, Sweeps and Corners
Tests:
  RISCV_LIB_tb_8TSRAM_READ_1: RISCV_LIB/tb_8TSRAM_READ/schematic, simulator spectre
    Variables: vddi = 1
    Outputs: /out_sa1; /out_sa2; /pchb1; /pchb2; /bl1; /bl2; /net2; /net1; /sae1; /sae2
