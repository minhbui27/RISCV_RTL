ADE simulation setup
Run mode: Single Run, Sweeps and Corners
Tests:
  RISCV_LIB_tb_8TSRAM_WRITE_1: RISCV_LIB/tb_8TSRAM_WRITE/schematic, simulator spectre
    Variables: vddi = 1
    Outputs: /out_sa; /bl; /blb; /wr_di; /wr_en; /wr_enb
