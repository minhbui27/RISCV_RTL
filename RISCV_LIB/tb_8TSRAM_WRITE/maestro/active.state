ADE simulation setup
Test RISCV_LIB_tb_8TSRAM_WRITE_1: RISCV_LIB/tb_8TSRAM_WRITE/schematic, simulator spectre
  Models: /fs/student/chanwhopark/ncsu45_template/hspice_nom.include
  Variables: vddi = 1
  Temperature: 27
  Analysis tran: start=0 stop=40n step=10p
  Signals: /out_sa, /bl, /blb, /wr_di, /wr_en, /wr_enb
Run mode: Single Run, Sweeps and Corners
