ADE simulation setup
Test RISCV_LIB_tb_4bit_CLABlock_1: RISCV_LIB/tb_4bit_CLABlock/schematic, simulator spectre
  Models: /fs/student/chanwhopark/ncsu45_template/hspice_nom.include
  Variables: vddi = 1
  Temperature: 27
  Analysis tran: stop=20n
  Signals: /Cin, /A<0:3>, /B<0:3>, /S<0:3>, /Cout
Run mode: Single Run, Sweeps and Corners
