ADE simulation setup
Run mode: Single Run, Sweeps and Corners
Tests:
  RISCV_LIB_tb_4bit_CLABlock_1: RISCV_LIB/tb_4bit_CLABlock/schematic, simulator spectre
    Variables: vddi = 1
    Outputs: /Cin; /A<0:3>; /B<0:3>; /S<0:3>; /Cout
