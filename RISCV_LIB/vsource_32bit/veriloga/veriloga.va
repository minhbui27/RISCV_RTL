`include "constants.vams"
`include "disciplines.vams"

module riscv_instr_source(output instr_bus[31:0]);
    electrical instr_bus[31:0]; // Declare each bit of the bus as a separate electrical signal
    parameter real clk_period = 1e-6; // Clock period (adjust as needed)
    integer instr_index; // Index to track the current instruction
    integer i; // Loop variable for assigning bits

    // Instruction memory as an array of integers
    integer instr_memory[0:5];

    analog begin
        // Initialize instruction memory
        @(initial_step) begin
            instr_memory[0] = 32'b00000000010100000000000110110111; // LUI x3, 0x5
            instr_memory[1] = 32'b00000000001100000010000100010011; // ADDI x2, x0, 0x3
            instr_memory[2] = 32'b00000000001000010000001010110011; // ADD x5, x2, x3
            instr_memory[3] = 32'b00000000000100001000001110110011; // SUB x7, x2, x1
            instr_memory[4] = 32'b00000000010100010010001100100011; // SW x5, 5(x3)
            instr_memory[5] = 32'b00000000010100011000001100000011; // LW x6, 5(x3)
            instr_index = 0; // Start with the first instruction
        end

        // Cycle through instructions
        @(timer(0, clk_period)) begin
            instr_index = (instr_index + 1) % 6; // Loop through instructions
        end

        // Assign the current instruction to the bus
        for (i = 0; i < 32; i = i + 1) begin
            instr_bus[i] <+ transition(
                (instr_memory[instr_index] >> i) & 1, 0, 1e-9, 1e-9
            );
        end
    end
endmodule
