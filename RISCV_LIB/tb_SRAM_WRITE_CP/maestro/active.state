ADE simulation setup
Test 00_ECE224A_SRAM_TUTORIAL_tb_tb_SRAM_WRITE_READ_CP_1: 00_ECE224A_SRAM_TUTORIAL_tb/tb_SRAM_WRITE_CP/schematic, simulator hspiceD
  Models: /fs/student/chanwhopark/ncsu45_template/hspice_nom.include
  Variables: vddi = 1
  Initial conditions: /I3/Q = 0; /I3/Qb = vddi
  Analysis tran: start=0 stop=40n step=10p
  Signals: /wr_en, /wr_di, /wl, /bl, /blb, /I3/Q, /I3/Qb, /out_sa
Run mode: Single Run, Sweeps and Corners
