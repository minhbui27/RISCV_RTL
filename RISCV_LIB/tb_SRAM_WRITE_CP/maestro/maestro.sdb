ADE simulation setup
Run mode: Single Run, Sweeps and Corners
Tests:
  00_ECE224A_SRAM_TUTORIAL_tb_tb_SRAM_WRITE_READ_CP_1: 00_ECE224A_SRAM_TUTORIAL_tb/tb_SRAM_WRITE_CP/schematic, simulator hspiceD
    Variables: vddi = 1
    Outputs: /wr_en; /wr_di; /wl; /bl; /blb; "/I3/Q"; "/I3/Qb"; /I3/Q; /I3/Qb; /out_sa
