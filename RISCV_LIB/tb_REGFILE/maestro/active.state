ADE simulation setup
Test ECE224_ETHAN_tb_REGFILE_1: ECE224_ETHAN/tb_REGFILE/schematic, simulator hspiceD
  Models: /fs/student/chanwhopark/ncsu45_template/hspice_nom.include
  Variables: vddi = 1
  Analysis tran: start=0 stop=50n step=10p
  Signals: /mem_wr, /mem_wrb
Test ECE224_ETHAN_tb_REGFILE_1_1: ECE224_ETHAN/tb_REGFILE/schematic, simulator hspiceD
  Models: /fs/student/chanwhopark/ncsu45_template/hspice_nom.include
  Variables: vddi = 1
  Analysis tran: start=0 stop=50n step=10p
  Signals: /mem_wr, /mem_wrb
Test ECE224_GITHUB_tb_REGFILE_1: ECE224_GITHUB/tb_REGFILE/schematic, simulator hspiceD
  Models: /fs/student/chanwhopark/ncsu45_template/hspice_nom.include
  Variables: vddi = 1
  Analysis tran: start=0 stop=75n step=10p
  Signals: /mem_wr, /I0/WL1<0:31>, /ck, /addr_en, /addr<0:4>, /pchb, /wr1_di<0:31>, /sa1_en, /rs1_out<0:31>, /I0/I4/BL1<0:31>, /I0/I4/BL1B<0:31>
Run mode: Single Run, Sweeps and Corners
Disabled tests: ECE224_ETHAN_tb_REGFILE_1, ECE224_ETHAN_tb_REGFILE_1_1
