ADE simulation setup
Run mode: Single Run, Sweeps and Corners
Tests:
  ECE224_ETHAN_tb_REGFILE_1 (off): ECE224_ETHAN/tb_REGFILE/schematic, simulator hspiceD
    Variables: vddi = 1
    Outputs: /rs1_out<0:31>; /wr1_en; /sa1_en; /ck; /addr_en; /wr1_di<0:31>; /rs1_addr<0:4>; /I0/I4/BL1<0:31>; /I0/I4/BL1B<0:31>; /pchb; /addr<0:4>; /mem_wr; /I0/WL1<0:31>; /I0/rs1_WL<0:31>; /I0/wr_WL<0:31>; /mem_wrb; /I0/mid
  ECE224_ETHAN_tb_REGFILE_1_1 (off): ECE224_ETHAN/tb_REGFILE/schematic, simulator hspiceD
    Variables: vddi = 1
    Outputs: /rs1_out<0:31>; /wr1_en; /sa1_en; /ck; /addr_en; /wr1_di<0:31>; /rs1_addr<0:4>; /I0/I4/BL1<0:31>; /I0/I4/BL1B<0:31>; /pchb; /addr<0:4>; /mem_wr; /I0/WL1<0:31>; /I0/rs1_WL<0:31>; /I0/wr_WL<0:31>; /mem_wrb; /I0/mid
  ECE224_GITHUB_tb_REGFILE_1: ECE224_GITHUB/tb_REGFILE/schematic, simulator hspiceD
    Variables: vddi = 1
    Outputs: /mem_wr; /I0/mid; /I0/WL1<0:31>; /mem_wrb; /ck; /addr_en; /addr<0:4>; /pchb; /wr1_di<0:31>; /sa1_en; /rs1_out<0:31>; /I0/I4/BL1<0:31>; /I0/I4/BL1B<0:31>
