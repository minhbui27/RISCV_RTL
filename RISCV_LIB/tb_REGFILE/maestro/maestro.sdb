ADE simulation setup
Run mode: Single Run, Sweeps and Corners
Tests:
  ECE224_GITHUB_tb_REGFILE_1: ECE224_GITHUB/tb_REGFILE/schematic, simulator hspiceD
    Variables: vddi = 1
    Outputs: /mem_wr; /I0/mid; /I0/WL1<0:31>; /mem_wrb; /ck; /addr_en; /addr<0:4>; /pchb; /wr1_di<0:31>; /sa1_en; /rs1_out<0:31>; /I0/I4/BL1<0:31>; /I0/I4/BL1B<0:31>
