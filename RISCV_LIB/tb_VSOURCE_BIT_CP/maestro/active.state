ADE simulation setup
Test 00_ECE224A_SRAM_TUTORIAL_tb_tb_VSOURCE_BIT_CP_1: 00_ECE224A_SRAM_TUTORIAL_tb/tb_VSOURCE_BIT_CP/schematic, simulator hspiceD
  Models: /fs/student/chanwhopark/ncsu45_template/hspice_nom.include
  Variables: vddi = 1
  Analysis tran: start=0 stop=100n step=10p
  Signals: /VOUT
Run mode: Single Run, Sweeps and Corners
