ADE simulation setup
Run mode: Single Run, Sweeps and Corners
Tests:
  00_ECE224A_SRAM_TUTORIAL_tb_tb_VSOURCE_BIT_CP_1: 00_ECE224A_SRAM_TUTORIAL_tb/tb_VSOURCE_BIT_CP/schematic, simulator hspiceD
    Variables: vddi = 1
