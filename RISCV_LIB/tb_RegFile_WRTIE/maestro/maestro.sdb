ADE simulation setup
Run mode: Single Run, Sweeps and Corners
Tests:
  ECE224_GITHUB_tb_RegFile_WRTIE_1: ECE224_GITHUB/tb_RegFile_WRTIE/schematic, simulator hspiceD
    Variables: vddi = 1
    Outputs: /wr1_en; /wr1_di<0:31>; "/I0/wr_addr<0:4>"; "/I0/WL<5>"; "/I0/WL1<5>"; "/I0/WL1<4>"; "/I0/I4/I2/BL<0:31>"; "/I0/I4/I2<5>/BL<0:31>"; "/I0/I4/I2<5>/BL1<0:31>"; /I0/wr_addr<0:4>; "/"; /; /wr_addr<0:4>; /I0/WL1<4>; /I0/I4/net1<0>; "/I0/I4/I2<4>/net1<0:31>"; "/I0/I4/I2<4>/BL1<0:31>"; "/I0/I4/I2<4>/I4/BL1<0:31>"; "/I0/I4/I2<4>/I4<0:31>"; "/I0/I4/I2<4>/I4<0:31>/BL1"; "/I0/I4/I2<4>/I4"; /I0/I4/I2<4>/I4; "/t"; /t; /I0/I4/I2<4>/C0<0:31>/PLUS; "/I0/I4/I2<4>"; "/I0/I4/I2<4>/BL1"; /I0/I4/I2<4>/BL1; /I0/I4/net1<0:31>; /I0/I4/net2<0:31>; /pchb
