ADE simulation setup
Test ECE224_GITHUB_tb_RegFile_WRTIE_1: ECE224_GITHUB/tb_RegFile_WRTIE/schematic, simulator hspiceD
  Models: /fs/student/chanwhopark/ncsu45_template/hspice_nom.include
  Variables: vddi = 1
  Analysis tran: start=0p stop=40n step=10p
  Signals: /wr1_en, /wr1_di<0:31>, /I0/WL1<4>, /wr_addr<0:4>, /I0/I4/I2<4>/C0<0:31>/PLUS (terminal)
Run mode: Single Run, Sweeps and Corners
