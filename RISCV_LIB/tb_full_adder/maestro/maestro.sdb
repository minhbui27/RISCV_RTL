ADE simulation setup
Run mode: Single Run, Sweeps and Corners
Tests:
  RISCV_LIB_tb_full_adder_1: RISCV_LIB/tb_full_adder/schematic, simulator spectre
    Variables: vddi = 1
    Outputs: /Cout; /Sum; /A; /B; /Cin
