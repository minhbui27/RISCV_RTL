ADE simulation setup
Test RISCV_LIB_tb_full_adder_1: RISCV_LIB/tb_full_adder/schematic, simulator spectre
  Models: /fs/student/chanwhopark/ncsu45_template/hspice_nom.include
  Variables: vddi = 1
  Temperature: 27
  Analysis tran: stop=30n
  Signals: /Cout, /Sum, /A, /B, /Cin
Run mode: Single Run, Sweeps and Corners
