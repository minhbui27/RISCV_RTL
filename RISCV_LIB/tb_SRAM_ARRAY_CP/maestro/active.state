ADE simulation setup
Test 00_ECE224A_SRAM_TUTORIAL_tb_tb_SRAM_ARRAY_CP_1: 00_ECE224A_SRAM_TUTORIAL_tb/tb_SRAM_ARRAY_CP/schematic, simulator hspiceD
  Models: /fs/student/chanwhopark/ncsu45_template/hspice_nom.include
  Variables: vddi = 1
  Initial conditions: /out_sa<0> = vddi; /blb<0> = 0; /bl<0> = vddi; /I1/I2/Qb = 0; /I1/I2/Q = vddi
  Analysis tran: start=0 stop=200n step=10p
  Signals: /wr_di<0>, /wr_en, /pchb, /wl<2>, /bl<0>, /blb<0>, /I1/I2/Q, /I1/I2/Qb, /sa_en, /out_sa<0>, /addr<1:0>, /ck, /addr_en
Run mode: Single Run, Sweeps and Corners
