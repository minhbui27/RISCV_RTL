ADE simulation setup
Run mode: Single Run, Sweeps and Corners
Tests:
  00_ECE224A_SRAM_TUTORIAL_tb_tb_SRAM_ARRAY_CP_1: 00_ECE224A_SRAM_TUTORIAL_tb/tb_SRAM_ARRAY_CP/schematic, simulator hspiceD
    Variables: vddi = 1
    Outputs: /wl<2>; /wr_di<0>; /bl<0>; /blb<0>; /out_sa<0>
